* SPICE netlist written by S-Edit Win32 7.03
* Written on Oct 19, 2026 at 18:15:59

* Waveform probing commands
.probe
.options probefilename="File0.dat"
+ probesdbfile="C:\Users\yooob\Desktop\4bit_reg\schematic\inverter\inverter.sdb"
+ probetopmodule="Module0"

* Main circuit: Module0
M1 y x Gnd Gnd NMOS L=2u W=22u AD=66p PD=24u AS=66p PS=24u
M2 y x Vdd Vdd PMOS L=2u W=22u AD=66p PD=24u AS=66p PS=24u
* End of main circuit: Module0
